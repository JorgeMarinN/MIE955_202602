** sch_path: /home/designer/shared/MIE955_202602/xschem/Proyecto/klayout/nmos_diff_pair.sch
.subckt nmos_diff_pair D_N S_COM B_COM IN_N
*.PININFO D_N:B S_COM:B B_COM:B IN_N:B
MM1 D_N IN_N S_COM B_COM sg13_lv_nmos w=1u l=0.13u ng=1 m=1
.ends
