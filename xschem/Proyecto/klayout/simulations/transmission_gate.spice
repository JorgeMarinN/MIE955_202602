** sch_path: /home/designer/shared/MIE955_202602/xschem/Proyecto/klayout/transmission_gate.sch
.subckt transmission_gate B GN A GP BN BP
*.PININFO B:B GN:B A:B GP:B BN:B BP:B
MM1 A GN B BN sg13_lv_nmos w=1u l=0.13u ng=1 m=1
MM2 A GP B BP sg13_lv_pmos w=3u l=0.13u ng=1 m=1
.ends
