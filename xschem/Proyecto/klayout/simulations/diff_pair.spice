** sch_path: /home/designer/shared/MIE955_202602/xschem/Proyecto/klayout/diff_pair.sch
.subckt diff_pair D_N D_P S_COM IN_P B_COM IN_N
*.PININFO D_N:B D_P:B S_COM:B IN_P:B B_COM:B IN_N:B
MM1 D_N IN_N S_COM B_COM sg13_lv_nmos w=1u l=0.13u ng=1 m=1
MM2 D_P IN_P S_COM B_COM sg13_lv_nmos w=1u l=0.13u ng=1 m=1
.ends
