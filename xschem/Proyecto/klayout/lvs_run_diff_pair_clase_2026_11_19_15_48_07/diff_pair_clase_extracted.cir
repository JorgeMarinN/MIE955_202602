* Extracted by KLayout with SG13G2 LVS runset on : 19/11/2026 15:48

.SUBCKT diff_pair_clase
M$1 \$2 \$5 \$3 \$1 sg13_lv_nmos L=0.5u W=1u AS=0.34p AD=0.34p PS=2.68u
+ PD=2.68u rfmode=0
M$2 \$3 \$6 \$4 \$1 sg13_lv_nmos L=0.5u W=1u AS=0.34p AD=0.34p PS=2.68u
+ PD=2.68u rfmode=0
.ENDS diff_pair_clase
