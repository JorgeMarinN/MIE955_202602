* Extracted by KLayout with SG13G2 LVS runset on : 19/11/2026 13:05

.SUBCKT diff_pair
M$1 \$3 \$6 \$4 \$1 sg13_lv_nmos L=0.13u W=1u AS=0.34p AD=0.34p PS=2.68u
+ PD=2.68u rfmode=0
M$2 \$4 \$7 \$5 \$1 sg13_lv_nmos L=0.13u W=1u AS=0.34p AD=0.34p PS=2.68u
+ PD=2.68u rfmode=0
R$3 \$2 \$1 ptap1 A=0.6084p P=3.12u
.ENDS diff_pair
