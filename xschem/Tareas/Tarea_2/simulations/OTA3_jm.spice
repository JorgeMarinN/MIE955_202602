** sch_path: /home/designer/shared/MIE955_202602/xschem/Tareas/Tarea_2/OTA3_jm.sch
**.subckt OTA3_jm IN_P IN_N OUT VDD VSS ibias
*.ipin IN_N
*.ipin IN_P
*.opin OUT
*.ipin VDD
*.ipin VSS
*.ipin ibias
C2 OUT Vo1_p 1p m=1
XM8 ibias ibias VSS VSS sg13_lv_nmos w=1u l=0.5u ng=1 m=1
XM7 Vsrc ibias VSS VSS sg13_lv_nmos w=1.5u l=0.5u ng=1 m=1
XM6 OUT ibias VSS VSS sg13_lv_nmos w=1u l=0.5u ng=1 m=5
XM1 Vo1_n IN_N Vsrc VSS sg13_lv_nmos w=1u l=0.5u ng=1 m=1
XM2 Vo1_p IN_P Vsrc VSS sg13_lv_nmos w=1u l=0.5u ng=1 m=1
XM3 Vo1_n Vo1_n VDD VDD sg13_lv_pmos w=1u l=0.8u ng=1 m=1
XM4 Vo1_p Vo1_n VDD VDD sg13_lv_pmos w=1u l=0.8u ng=1 m=1
XM5 OUT Vo1_p VDD VDD sg13_lv_pmos w=5u l=0.5u ng=1 m=5
**.ends
.end
