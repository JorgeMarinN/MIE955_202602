** sch_path: /home/designer/shared/MIE955_202602/xschem/Tareas/Tarea_1/nmoslv_charac_MIE955-202602-HW1.sch
**.subckt nmoslv_charac_MIE955-202602-HW1 g1 d1
*.ipin g1
*.iopin d1
XM1 GND g1 d1 GND sg13_lv_nmos w=5u l=0.5u ng=1 m=1
**** begin user architecture code

vgs g1 0 dc=0.75
vds d1 0 dc=0.75

.control
save all
*  set color0 = white

save @n.xm1.nsg13_lv_nmos[ids]
save @n.xm1.nsg13_lv_nmos[gm]

dc vgs 0.01 1.2 0.01
*dc vds 0.01 1.2 0.01 vgs 0.1 1.2 0.3

let idn = @n.xm1.nsg13_lv_nmos[ids]
let gmn = @n.xm1.nsg13_lv_nmos[gm]
let vthn = @n.xm1.nsg13_lv_nmos[vth]
let vgsn = @n.xm1.nsg13_lv_nmos[vgs]
let vdsatn = @n.xm1.nsg13_lv_nmos[vdss]
let cgg = @n.xm1.nsg13_lv_nmos[cgg]
let cgsol = @n.xm1.nsg13_lv_nmos[cgsol]
let cgdol = @n.xm1.nsg13_lv_nmos[cgdol]
let vov = 2*idn/gmn
let gmoverId = gmn/idn
let cgg_tot = cgg + cgsol + cgdol
let ft = 1e-9*gmn/6.28/cgg_tot
*let idnoverw = idn/W

plot idn
*plot ylog idn
*plot gmn
*plot xlog gmoverId
*plot gmoverId

wrdata /home/designer/shared/MIE955_202602/sim_data/data_nmos_idvgs_VDSp9_test.txt idn

wrdata /home/designer/shared/MIE955_202602/sim_data/data_nmos_idvgs_VDSp9_gmid-ft.txt gmoverId ft

let W = 5e-6
setscale gmoverId
*plot idn/W
*plot vov

.endc

.lib cornerMOShv.lib mos_tt
.lib cornerMOSlv.lib mos_tt
*.lib cornerMOShv.lib mos_ff
*.lib cornerMOSlv.lib mos_ff
*.lib cornerMOShv.lib mos_ss
*.lib cornerMOSlv.lib mos_ss
*.lib cornerMOShv.lib mos_sf
*.lib cornerMOSlv.lib mos_sf
*.lib cornerMOShv.lib mos_fs
*.lib cornerMOSlv.lib mos_fs

.include /opt/pdks/ihp-sg13g2/libs.ref/sg13g2_stdcell/spice/sg13g2_stdcell.spice
.lib /opt/pdks/ihp-sg13g2/libs.tech/ngspice/models/cornerRES.lib res_typ
.lib /opt/pdks/ihp-sg13g2/libs.tech/ngspice/models/cornerCAP.lib cap_typ
*.lib /opt/pdks/ihp-sg13g2/libs.tech/ngspice/models/diodes.lib

**** end user architecture code
**.ends
.GLOBAL GND
.end
