** sch_path: /home/designer/shared/MIE955_202602/xschem/Tareas/Tarea_1/cs_amp_full_FIXED_MIE955HW1.sch
**.subckt cs_amp_full_FIXED_MIE955HW1 vout
*.iopin vout
I1 VDD vout 160u
XM1 vout vg GND GND sg13_lv_nmos w=47u l=0.45u ng=10 m=1
B1 net1 GND V = 0.6*(1+tanh(10000*(v(vfb)-v(vref)))) m=1
V1 vg net1 dc 0 ac 1
R1 vfb vout 10000000 m=1
C2 vfb GND 10 m=1
**** begin user architecture code

.option wnflag=1
vsup VDD 0 1.2
vref vref 0 0.6

cload vout 0 5p

.control
save all

save @n.xm1.nsg13_lv_nmos[gm]
save @n.xm1.nsg13_lv_nmos[ids]
save @n.xm1.nsg13_lv_nmos[gds]

*let gdsn = @n.xm1.nsg13_lv_nmos[gds]
*let gmn = @n.xm1.nsg13_lv_nmos[gm]
*let vthn = @n.xm1.nsg13_lv_nmos[vth]
*let idn = @n.xm1.nsg13_lv_nmos[ids]
*let ao = gmn / gdsn

*plot deriv(v(vout)) vs v(vout) ao vs v(vout)

ac dec 100 1 1T
plot vdb(vout)

op
print vg
print vout

.endc

.param corner=0

.if (corner==0)
.lib cornerMOSlv.lib mos_tt
.lib cornerRES.lib res_typ
.lib cornerCAP.lib cap_typ
.endif

**** end user architecture code
**.ends
.GLOBAL GND
.GLOBAL VDD
.end
